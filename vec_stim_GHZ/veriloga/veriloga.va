// VerilogA for Project2, vec_stim_GHZ, veriloga

`include "constants.vams"
`include "disciplines.vams"

module vec_stim_1ns(a, b, cin);
  electrical [15:0] a;
  electrical [15:0] b;
  electrical cin;

  parameter real vhigh = 1.2;
  parameter real tper  = 1n from (0:inf);   // hold time per vector
  parameter real trf   = 10p from (0:inf);  // edge time

  integer cnt, i;
  integer va, vb;
  integer abit[0:15], bbit[0:15];

  analog begin
    @(initial_step) cnt = 0;
    @(timer(tper, tper)) cnt = cnt + 1;

    // Vector A, Vector B, Vector C, then hold the last one
    if (cnt == 0) begin
      va = 65535; vb = 1;        // Vector A: FFFF + 0001
    end else if (cnt == 1) begin
      va = 65535; vb = 65535;    // Vector B: FFFF + FFFF
    end else begin
      va = 43690; vb = 43690;    // Vector C: AAAA + AAAA
    end

    // Split the words into 0/1 bit arrays
    for (i = 0; i < 16; i = i + 1) begin
      abit[i] = (va >> i) & 1;
      bbit[i] = (vb >> i) & 1;
    end

    // Port indices must be constants, so each bit is written out
    V(a[0])  <+ transition(abit[0]  ? vhigh : 0.0, 0, trf);
    V(a[1])  <+ transition(abit[1]  ? vhigh : 0.0, 0, trf);
    V(a[2])  <+ transition(abit[2]  ? vhigh : 0.0, 0, trf);
    V(a[3])  <+ transition(abit[3]  ? vhigh : 0.0, 0, trf);
    V(a[4])  <+ transition(abit[4]  ? vhigh : 0.0, 0, trf);
    V(a[5])  <+ transition(abit[5]  ? vhigh : 0.0, 0, trf);
    V(a[6])  <+ transition(abit[6]  ? vhigh : 0.0, 0, trf);
    V(a[7])  <+ transition(abit[7]  ? vhigh : 0.0, 0, trf);
    V(a[8])  <+ transition(abit[8]  ? vhigh : 0.0, 0, trf);
    V(a[9])  <+ transition(abit[9]  ? vhigh : 0.0, 0, trf);
    V(a[10]) <+ transition(abit[10] ? vhigh : 0.0, 0, trf);
    V(a[11]) <+ transition(abit[11] ? vhigh : 0.0, 0, trf);
    V(a[12]) <+ transition(abit[12] ? vhigh : 0.0, 0, trf);
    V(a[13]) <+ transition(abit[13] ? vhigh : 0.0, 0, trf);
    V(a[14]) <+ transition(abit[14] ? vhigh : 0.0, 0, trf);
    V(a[15]) <+ transition(abit[15] ? vhigh : 0.0, 0, trf);

    V(b[0])  <+ transition(bbit[0]  ? vhigh : 0.0, 0, trf);
    V(b[1])  <+ transition(bbit[1]  ? vhigh : 0.0, 0, trf);
    V(b[2])  <+ transition(bbit[2]  ? vhigh : 0.0, 0, trf);
    V(b[3])  <+ transition(bbit[3]  ? vhigh : 0.0, 0, trf);
    V(b[4])  <+ transition(bbit[4]  ? vhigh : 0.0, 0, trf);
    V(b[5])  <+ transition(bbit[5]  ? vhigh : 0.0, 0, trf);
    V(b[6])  <+ transition(bbit[6]  ? vhigh : 0.0, 0, trf);
    V(b[7])  <+ transition(bbit[7]  ? vhigh : 0.0, 0, trf);
    V(b[8])  <+ transition(bbit[8]  ? vhigh : 0.0, 0, trf);
    V(b[9])  <+ transition(bbit[9]  ? vhigh : 0.0, 0, trf);
    V(b[10]) <+ transition(bbit[10] ? vhigh : 0.0, 0, trf);
    V(b[11]) <+ transition(bbit[11] ? vhigh : 0.0, 0, trf);
    V(b[12]) <+ transition(bbit[12] ? vhigh : 0.0, 0, trf);
    V(b[13]) <+ transition(bbit[13] ? vhigh : 0.0, 0, trf);
    V(b[14]) <+ transition(bbit[14] ? vhigh : 0.0, 0, trf);
    V(b[15]) <+ transition(bbit[15] ? vhigh : 0.0, 0, trf);

    V(cin) <+ transition(0.0, 0, trf);   // CIN = 0 for all vectors

    $bound_step(trf);
  end
endmodule
